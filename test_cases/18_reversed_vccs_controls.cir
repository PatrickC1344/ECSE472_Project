VCCS Reversed Control and Output
Vin n1 0 dc 8
R1 n1 n2 1000
R2 n2 0 1000
VCCS1 0 n3 n2 n1 0.001
R3 n3 0 1000
.dc
.end
