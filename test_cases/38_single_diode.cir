Single forward-biased diode
* Diode parameters: Is = 1e-15 A; Vt = 0.025 V (set in solver).
VIN N1 0 DC 1
D1 N1 N2
R1 N2 0 50
.dc
.end
