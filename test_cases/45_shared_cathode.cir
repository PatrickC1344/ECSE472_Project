Two diodes sharing a cathode
* Diode parameters: Is = 1e-15 A; Vt = 0.025 V (set in solver).
V1 N1 0 DC 1
V2 N2 0 DC 1.5
R1 N1 N3 1000
R2 N2 N4 1000
D1 N3 N5
D2 N4 N5
R3 N5 0 500
.dc
.end
