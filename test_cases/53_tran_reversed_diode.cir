Reversed diode and sensor-controlled outputs
* Is=1e-15 A; Vt=0.025 V, configured in fill_diodes.
VIN N1 0 SIN 1.5 120
R1 N1 N2 1000
ISC1 N2 N3
D1 0 N3
CCCS1 N4 0 ISC1 2
R2 N4 0 1000
CCVS1 N5 0 ISC1 500
R3 N5 0 1000
.TRAN 0.02S 0.02MS
.END
