VCVS Shared Output and Control Node
Vin n1 0 dc 10
R1 n1 n2 1000
R2 n2 0 2000
VCVS1 n3 0 n3 n2 0.5
R3 n3 0 1000
.dc
.end
