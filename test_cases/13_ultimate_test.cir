Ultimate MNA All Elements DC Test
Vin n1 0 dc 12
R1 n1 n2 1000
R2 n2 0 2000
C1 n2 0 0.000001
L1 n2 n3 0.01
R3 n3 0 3000
Isrc n3 0 dc 0.001
ISC1 n3 n4
R4 n4 0 4000
VCCS1 n5 0 n1 n2 0.0005
R5 n5 0 1000
VCVS1 n6 0 n2 n4 1.5
R6 n6 0 2000
CCCS1 n7 0 ISC1 2
R7 n7 0 1000
CCVS1 n8 0 ISC1 500
R8 n8 0 1000
.dc
.end
