Current source injection to grounded resistor
Iin n1 0 0.002
Rload n1 0 1000
.dc
.end
