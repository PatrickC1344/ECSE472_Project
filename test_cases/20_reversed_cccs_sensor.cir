CCCS Negative Sensing Direction
Vin n1 0 dc 10
R1 n1 n2 1000
ISC1 n3 n2
R2 n3 0 1000
CCCS1 0 n4 ISC1 -2
R4 n4 0 1000
.dc
.end
