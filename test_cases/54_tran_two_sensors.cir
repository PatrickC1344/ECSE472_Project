Two diode branches, frequencies and shared output
* Is=1e-15 A; Vt=0.025 V, configured in fill_diodes.
V1 N1 0 SIN 2 50
R1 N1 N2 1000
ISC1 N2 N3
D1 N3 0
V2 N6 0 COS 1.5 100
R4 N6 N7 1000
ISC2 N7 N8
D2 0 N8
CCCS1 N4 0 ISC1 2
CCCS2 N4 0 ISC2 -1
R2 N4 0 1000
CCVS1 N5 0 ISC1 500
R3 N5 0 1000
.TRAN 0.04S 0.025MS
.END
