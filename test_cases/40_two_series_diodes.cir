Two series diodes
* Diode parameters: Is = 1e-15 A; Vt = 0.025 V (set in solver).
VIN N1 0 DC 2
R1 N1 N2 1000
D1 N2 N3
D2 N3 0
.dc
.end
