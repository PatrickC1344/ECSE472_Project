Numerical Scale Mix
Vin n1 0 dc 3
R1 n1 n2 1000000
R2 n2 0 1000
C1 n2 0 0.000000000001
I1 n2 0 0.000000001
.dc
.end
