Voltage and current excitation with default step size
* Is=1e-15 A; Vt=0.025 V, configured in fill_diodes.
VIN N1 0 SIN 1 25
IIN 0 N1 COS 0.001 25
R1 N1 N2 1000
ISC1 N2 N3
D1 N3 0
CCCS1 N4 0 ISC1 2
R2 N4 0 1000
CCVS1 N5 0 ISC1 500
R3 N5 0 1000
.TRAN 0.03S
.END
